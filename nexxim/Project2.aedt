# Ansys Electronics Desktop project, version 2025.1

design Circuit1 (Circuit)
options: SParamCircuitDef IntegrationMethod=FFT
components:
  S1 = PCB3()
  port RXN rz=50ohm iz=0ohm EnableNoise=false noisetemp=16.85cel
  port RXP rz=50ohm iz=0ohm EnableNoise=false noisetemp=16.85cel
  port TXN rz=50ohm iz=0ohm EnableNoise=false noisetemp=16.85cel
  port TXP rz=50ohm iz=0ohm EnableNoise=false noisetemp=16.85cel
nets:
  RXN: S1.C_N_J2_1
  RXP: S1.C_P_J2_2
  TXN: S1.C_N_J1_2
  TXP: S1.C_P_J1_1
setups:
  LinearFrequency: LinearFrequencyData(false, 0.1, false, "", false) SweepDefinition{Variable=Freq Data="LIN 0GHz 40GHz 10MHz"}
output variables:
  SDD21 = 0.5*(S(RXP,TXP) - S(RXP,TXN) - S(RXN,TXP) + S(RXN,TXN))
  SDD11 = 0.5*(S(TXP,TXP) - S(TXP,TXN) - S(TXN,TXP) + S(TXN,TXN))
reports:
  Output Variables Plot1: dB20(SDD11) vs Freq on LinearFrequency : LinearFrequency; markers m1 at 12.56GHz, m2 at 28.05GHz
  Output Variables Plot2: dB20(SDD21) vs Freq on LinearFrequency : LinearFrequency; markers m1 at 12.56GHz, m2 at 28.05GHz

design Circuit2 (Circuit)
options: SParamCircuitDef IntegrationMethod=FFT
components:
  S1 = PCB3()
  A3 = EYESOURCE_DIFF(trise=1ps tfall=1ps UIorBPSValue=1.79e-11s modulation=PAM4 step_resp_num_ui=600)
  A4 = EYEPROBE_DIFF(source_name=AEYESOURCE3)
  R5 = RES_()
  R6 = RES_()
nets:
  0: R5.0, R6.1
  net_10: S1.C_N_J2_1, A4.1, R5.1
  net_7: S1.C_P_J1_1, A3.0
  net_8: S1.C_N_J1_2, A3.1
  net_9: S1.C_P_J2_2, A4.0, R6.0
setups:
  QuickEyeAnalysis: QuickEyeAnalysis(false, 1e-9, false, 0, "", true, true, 32)
  VerifEyeAnalysis: VerifEyeAnalysis(false, 1e-9, false, 0, "", true, true, 32)
output variables:
  SDD21 = 0.5*(S(RXP,TXP) - S(RXP,TXN) - S(RXN,TXP) + S(RXN,TXN))
  SDD11 = 0.5*(S(TXP,TXP) - S(TXP,TXN) - S(TXN,TXP) + S(TXN,TXN))
reports:
  QuickEye Voltage Plot1: AEYEPROBE(required) vs Time on QuickEyeAnalysis : QuickEyeAnalysis
  VerifEye Bathtub Plot1: AEYEPROBE(required)<Bit Error Rate> vs __UnitInterval on VerifEyeAnalysis : VerifEyeAnalysis [__EyeOpening=all]; markers MY1 at y=0.00024
